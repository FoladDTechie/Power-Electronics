* Charger connected, CHG disabled, DSG enabled. Node 0 = VSS (B-)
.include models.lib
VB BSRC 0 18.0
RINT BSRC PACKP 50m
* charger: 25.2 V behind 0.5 ohm [ASSUMPTION]
VCHGR CHPLUS CHMINUS 25.2
RCH CHPLUS PACKP 0.5
VIM CHMINUS PACKN 0
DTVS PACKN PACKP SMCJ26A
* CHG pin disabled: internal pull-down 750k to VSS (datasheet 750k-1.25M)
RCHGOFF CHGPIN 0 750k
DCHG CHGPIN CHGA D1N4148W
RCHG CHGA GQ2 1k
RGS2 GQ2 PACKN 100k
DZ PACKN GQ2 BZX84C15
MQ2 MID GQ2 PACKN PACKN IPT012
DB2 PACKN MID DBODYM
VDSG GQ1 0 12
MQ1 MID GQ1 SNS SNS IPT012
DB1 SNS MID DBODYM
RSNS SNS 0 1m
.control
op
print v(GQ2)-v(PACKN) v(PACKN) i(VIM)
quit
.endc
.end
